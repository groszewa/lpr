_vVin (Vin 0) vsource val0=0 val1=1.2 period=4n delay=1n rise=100p fall=100p width=2n type=pulse
