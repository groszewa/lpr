// Design: ajgrosze_scratch/q1_an
simulator lang=spectre
global 0
include "/home/ecelrc/students/agroszewski/lpr/hw1/test/32nm_LP.pm"

// ajgrosze_scratch/q1_an/schematic
V0 (net5 0) vsource dc=1.2 type=dc
M0 (Vout Vin 0 0) nmos w=320.00n l=32.000n
M1 (Vout Vin net5 net5) pmos w=320.00n l=32.000n
include "./_graphical_stimuli.scs"
simulatorOptions options temp=27
tran tran stop=10n
save V0:p V0:p M1:d M0:d
