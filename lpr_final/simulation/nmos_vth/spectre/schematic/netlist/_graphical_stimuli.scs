_vVin (Vin 0) vsource dc=Vsweep type=dc
